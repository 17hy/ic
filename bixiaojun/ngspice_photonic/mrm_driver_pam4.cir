* MRM PAM-4 driver macro model with R+L output peaking
* Based on Fig. 23.3.3. Ideal logic/driver sources plus RC/L load.

.options method=gear reltol=1e-5 abstol=1e-12 vntol=1e-7
.param rdrv=26
.param cmrm=300f
.param lpk=90p
.param rpk=1e9
.param tr=2p

* AC bandwidth comparison: no peaking vs R+L peaking into MRM capacitance.
VAC acsrc 0 AC 1
RDRV0 acsrc out_no  {rdrv}
CMRM0 out_no 0 {cmrm}
RLEAK0 out_no 0 20k
RDRV1 acsrc pre_pk {rdrv}
LPK pre_pk out_pk {lpk}
RPK pre_pk out_pk {rpk}
CMRM1 out_pk 0 {cmrm}
RLEAK1 out_pk 0 20k

* PAM-4 transient source. MSB/LSB make four electrical drive levels.
VMSB msb 0 PULSE(0 1 0 {tr} {tr} 80p 160p)
VLSB lsb 0 PULSE(0 1 20p {tr} {tr} 40p 80p)
BPAM pam 0 V={0.25 + 0.85*V(msb) + 0.425*V(lsb)}
RDRV2 pam pre_tr {rdrv}
LPK2 pre_tr out_tr {lpk}
RPK2 pre_tr out_tr {rpk}
CMRM2 out_tr 0 {cmrm}
RLEAK2 out_tr 0 20k

.control
ac dec 300 100meg 120gig
wrdata mrm_driver_ac.csv frequency vdb(out_no) vdb(out_pk)
tran 0.2p 1.2n 0 0.2p
meas tran vmin MIN v(out_tr) from=0.2n to=1.2n
meas tran vmax MAX v(out_tr) from=0.2n to=1.2n
print vmin vmax
wrdata mrm_driver_pam4.csv time v(msb) v(lsb) v(pam) v(out_tr)
quit
.endc
.end
