* chain_1_stage: 1-stage inverter buffer chain
.include ../models/chapter5_cmos.inc
Vdd vdd 0 2.5
Vin in 0 PULSE(0 2.5 0.2n 20p 20p 1n 2n)
X1 in out vdd inv wnn=1e-06 wpp=2.75e-06 lch=2.5e-07
Cload out 0 1e-12

.control
set noaskquit
set wr_singlescale
set wr_vecnames
tran 1p 10n
wrdata ../raw/chain_1_stage.dat time v(in) v(out) i(vdd)
quit
.endc
.end
