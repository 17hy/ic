* 03_load_regulation.cir
* Sweep load current to observe load regulation.

.include ./ldo_macromodel.inc
.options reltol=1e-5 abstol=1e-12 vntol=1e-6

Vvin vin 0 3.3
Vref vref 0 1.2
Iload vout 0 1m

Xldo vin vout vref fb gate ldo_pmos params: rtop=400k rbot=600k cout=10u esr=50m fp_ea=20k wpass=30000u

.dc Iload 1m 250m 1m

.control
set filetype=ascii
run
plot v(vout)
plot v(fb)
plot v(gate)
wrdata 03_load_regulation.csv v(vout) v(fb) v(gate)

.endc

.end
