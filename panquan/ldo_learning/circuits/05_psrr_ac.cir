* 05_psrr_ac.cir
* AC transfer from input ripple to output ripple.
* VIN has AC=1, so vdb(vout) is VOUT_ripple/VIN_ripple in dB.

.include ./ldo_macromodel.inc
.options reltol=1e-5 abstol=1e-12 vntol=1e-6

Vvin vin 0 DC 3.3 AC 1
Vref vref 0 1.2
Iload vout 0 50m

Xldo vin vout vref fb gate ldo_pmos params: rtop=400k rbot=600k cout=10u esr=50m fp_ea=20k wpass=30000u cgate=300p

.ac dec 200 10 100meg

.control
set filetype=ascii
run
wrdata 05_psrr_ac.csv frequency vdb(vout) vp(vout)
quit
.endc

.end
