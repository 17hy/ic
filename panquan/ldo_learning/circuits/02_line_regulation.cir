* 02_line_regulation.cir
* Sweep VIN to observe line regulation and dropout.

.include ./ldo_macromodel.inc
.options reltol=1e-5 abstol=1e-12 vntol=1e-6

Vvin vin 0 3.3
Vref vref 0 1.2
Iload vout 0 50m

Xldo vin vout vref fb gate ldo_pmos params: rtop=400k rbot=600k cout=10u esr=50m fp_ea=20k wpass=30000u

.dc Vvin 1.6 5.0 0.01

.control
set filetype=ascii
run
wrdata 02_line_regulation.csv v(vin) v(vout) v(fb) v(gate)
quit
.endc

.end
