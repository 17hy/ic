* Large-signal paper-style XCEA + SSF LDO PSR.

.include ../../circuits/paper_ldo_xcea_ssf_macro.inc
.options reltol=1e-5 abstol=1e-12 vntol=1e-8

Vvin vin 0 DC 3.3 AC 1
Vref vref 0 1.2
Iload vout 0 15m

Xldo vin vout vref fb gate xcea ssf paper_ldo_xcea_ssf_macro

.control
set filetype=ascii
op
print v(vin) v(vout) v(fb) v(gate) v(xcea)
ac dec 200 1k 1gig
wrdata results/large_signal_xcea_ssf_psr.csv frequency vdb(vout) vp(vout) vdb(gate)
meas ac psr_1meg find vdb(vout) at=1meg
quit
.endc

.end
