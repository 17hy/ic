* ch04_01_basic_diff_pair_dc: differential-pair large-signal transfer
.include ../../models/educational_cmos.inc
Vdd vdd 0 {VDD}
Vcm cm 0 DC 0.85
Vdm dm 0 DC 0
Bip inp 0 v={v(cm)+v(dm)/2}
Bin inm 0 v={v(cm)-v(dm)/2}
Rd1 vdd outp 8k
Rd2 vdd outn 8k
M1 outp inp tail 0 NMOS W=8u L=0.18u
M2 outn inm tail 0 NMOS W=8u L=0.18u
Itail tail 0 DC 160u

.control
set noaskquit
set wr_singlescale
set wr_vecnames
dc Vdm -0.8 0.8 0.005
let voutdiff = v(outp) - v(outn)
wrdata ../../results/ch04_01_basic_diff_pair_dc.dat v(dm) v(outp) v(outn) voutdiff
quit
.endc
.end
