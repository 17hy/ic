* ch04_02_diff_pair_ac_gain: differential-mode small-signal gain
.include ../../models/educational_cmos.inc
Vdd vdd 0 {VDD}
Vcm cm 0 DC 0.85 AC 0
Vdm dm 0 DC 0 AC 1m
Bip inp 0 v={v(cm)+v(dm)/2}
Bin inm 0 v={v(cm)-v(dm)/2}
Rd1 vdd outp 8k
Rd2 vdd outn 8k
M1 outp inp tail 0 NMOS W=8u L=0.18u
M2 outn inm tail 0 NMOS W=8u L=0.18u
Itail tail 0 DC 160u

.control
set noaskquit
set wr_singlescale
set wr_vecnames
ac dec 80 10 10G
wrdata ../../results/ch04_02_diff_pair_ac_gain.dat frequency vdb(outp,outn) vp(outp,outn)
quit
.endc
.end
