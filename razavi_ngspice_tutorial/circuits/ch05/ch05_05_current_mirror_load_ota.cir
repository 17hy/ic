* ch05_05_current_mirror_load_ota: five-transistor OTA with PMOS mirror load

.include ../../models/educational_cmos.inc

.param VDD=1.8

Vdd vdd 0 {VDD}
Vcm cm 0 DC 0.85
Vdm dm 0 DC 0 AC 1m

Bip inp 0 v={v(cm)+v(dm)/2}
Bin inm 0 v={v(cm)-v(dm)/2}

M1 x   inp tail 0   NMOS W=8u  L=0.18u
M2 out inm tail 0   NMOS W=8u  L=0.18u
M3 x   x   vdd  vdd PMOS W=10u L=0.18u
M4 out x   vdd  vdd PMOS W=10u L=0.18u
M5 tail nb 0    0   NMOS W=12u L=0.18u

Vnb nb 0 DC 0.68

.control
set noaskquit
set wr_singlescale
set wr_vecnames
set hcopydevtype=svg

* 差模输入 DC 扫描
dc Vdm -0.25 0.25 0.002

* 差模输入
let vid = v(inp) - v(inm)

* 输入端电压
plot v(inp) v(inm) vid title "Differential Input Voltages"

* 输出电压随差模输入变化
plot v(out) vs vid title "Large-Signal VTC: Vout vs Vid"

* 差模增益
plot deriv(v(out)) vs vid title "Differential DC Gain dVout/dVid"

* 保存图片
hardcopy ../../results/ch05_05_ota_input_nodes.svg v(inp) v(inm) vid
hardcopy ../../results/ch05_05_ota_vout_vs_vid.svg v(out) vs vid
hardcopy ../../results/ch05_05_ota_dc_gain_vs_vid.svg deriv(v(out)) vs vid

* 保存数据
wrdata ../../results/ch05_05_ota_dc.dat vid v(inp) v(inm) v(out) v(x) v(tail)

.endc

.end
