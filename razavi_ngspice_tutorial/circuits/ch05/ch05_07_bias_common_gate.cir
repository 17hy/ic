* ch05_07_bias_common_gate: current mirror biased common-gate amplifier
.include ../../models/educational_cmos.inc
Vdd vdd 0 {VDD}
Vin in 0 DC 0.35 AC 1m
Vg gate 0 DC 0.95
Iref vdd pref DC 130u
Mref pref pref vdd vdd PMOS W=8u L=0.18u
Mload out pref vdd vdd PMOS W=8u L=0.18u
M1 out gate in 0 NMOS W=8u L=0.18u

.control
set noaskquit
set wr_singlescale
set wr_vecnames
op
print v(out) v(pref) v(in)
ac dec 80 10 10G
wrdata ../../results/ch05_07_bias_common_gate_ac.dat frequency vdb(out) vp(out)
quit
.endc
.end
