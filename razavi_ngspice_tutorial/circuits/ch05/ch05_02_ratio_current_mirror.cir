* ch05_02_ratio_current_mirror: 1x, 2x, and 4x mirror branches
.include ../../models/educational_cmos.inc
Vdd vdd 0 {VDD}
Iref vdd ref DC 50u
Vout1 out1 0 DC 1.0
Vout2 out2 0 DC 1.0
Vout4 out4 0 DC 1.0
Mref ref ref 0 0 NMOS W=5u L=0.18u
M1 out1 ref 0 0 NMOS W=5u L=0.18u
M2 out2 ref 0 0 NMOS W=10u L=0.18u
M4 out4 ref 0 0 NMOS W=20u L=0.18u

.control
set noaskquit
set wr_singlescale
set wr_vecnames
op
print i(vout1) i(vout2) i(vout4) v(ref)
dc Vout1 0 1.8 0.01
wrdata ../../results/ch05_02_ratio_current_mirror_vout1.dat v(out1) i(vout1)
quit
.endc
.end
