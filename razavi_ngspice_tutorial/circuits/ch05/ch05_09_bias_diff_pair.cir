* ch05_09_bias_diff_pair: mirror-biased differential pair
.include ../../models/educational_cmos.inc
Vdd vdd 0 {VDD}
Vcm cm 0 DC 0.85
Vdm dm 0 DC 0 AC 1m
Bip inp 0 v={v(cm)+v(dm)/2}
Bin inm 0 v={v(cm)-v(dm)/2}
Iref vdd nref DC 160u
Mref nref nref 0 0 NMOS W=12u L=0.18u
Mtail tail nref 0 0 NMOS W=12u L=0.18u
Rd1 vdd outp 8k
Rd2 vdd outn 8k
M1 outp inp tail 0 NMOS W=8u L=0.18u
M2 outn inm tail 0 NMOS W=8u L=0.18u

.control
set noaskquit
set wr_singlescale
set wr_vecnames
set hcopydevtype=svg
dc Vdm -0.5 0.5 0.005
let voutdiff = v(outp) - v(outn)
plot voutdiff vs v(dm) title "ch05_09 VOD-VDM"
hardcopy ../../results/ch05_09_bias_diff_pair_dc.svg voutdiff vs v(dm)
wrdata ../../results/ch05_09_bias_diff_pair_dc.dat v(dm) voutdiff v(tail)
ac dec 80 10 10G
plot vdb(outp,outn) title "ch05_09 Differential AC Gain"
hardcopy ../../results/ch05_09_bias_diff_pair_gain.svg vdb(outp,outn)
plot {180/PI*vp(outp,outn)} title "ch05_09 Differential AC Phase"
hardcopy ../../results/ch05_09_bias_diff_pair_phase.svg {180/PI*vp(outp,outn)}
wrdata ../../results/ch05_09_bias_diff_pair_ac.dat frequency vdb(outp,outn) vp(outp,outn)
quit
.endc
.end
