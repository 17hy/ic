* ch03_06_cs_source_degeneration: common-source with source degeneration
.include ../../models/educational_cmos.inc
Vdd vdd 0 {VDD}
Vin in 0 DC 0.85 AC 1m
Rd vdd out 5k
Rs src 0 800
M1 out in src 0 NMOS W=8u L=0.18u

.control
set noaskquit
set wr_singlescale
set wr_vecnames
dc Vin 0 1.8 0.005
wrdata ../../results/ch03_06_cs_source_degeneration_dc.dat v(in) v(out) v(src)
ac dec 80 10 10G
wrdata ../../results/ch03_06_cs_source_degeneration_ac.dat frequency vdb(out) vp(out)
quit
.endc
.end
