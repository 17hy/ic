* ch03_09_cascode_stage: NMOS common-source common-gate cascode
.include ../../models/educational_cmos.inc
Vdd vdd 0 {VDD}
Vin in 0 DC 0.7 AC 1m
Vcas cas 0 DC 1.05
Iload vdd out DC 140u
M1 x in 0 0 NMOS W=4u L=0.18u
M2 out cas x 0 NMOS W=4u L=0.18u

.control
set noaskquit
set wr_singlescale
set wr_vecnames
op
print v(out) v(x) @m1[gm] @m2[gds]
ac dec 80 10 10G
wrdata ../../results/ch03_09_cascode_stage_ac.dat frequency vdb(out) vp(out)
quit
.endc
.end
