* ch03_08_common_gate: common-gate amplifier
.include ../../models/educational_cmos.inc
Vdd vdd 0 {VDD}
Vin in 0 DC 0.35 AC 1m
Vg gate 0 DC 0.95
Rd vdd out 6k
M1 out gate in 0 NMOS W=8u L=0.18u

.control
set noaskquit
set wr_singlescale
set wr_vecnames
op
print v(out) v(in) @m1[gm]
ac dec 80 10 10G
wrdata ../../results/ch03_08_common_gate_ac.dat frequency vdb(out) vp(out)
quit
.endc
.end
