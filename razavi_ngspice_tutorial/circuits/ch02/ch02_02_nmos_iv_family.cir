* ch02_02_nmos_iv_family: ID-VDS family with VGS stepping
.include ../../models/educational_cmos.inc
Vgs gate 0 0
Vds drain 0 0
M1 drain gate 0 0 NMOS W=10u L=0.18u

.control
set noaskquit
set wr_singlescale
set wr_vecnames

* 执行双重直流扫描：主扫描是 Vds，副扫描是 Vgs
dc Vds 0 1.8 0.01 Vgs 0.5 1.3 0.2

* 【新增】直接画出输出特性曲线 (ID vs VDS)
* 注意：在 SPICE 中，流过电压源 Vds 的电流规定为从正极流向负极。
* 实际流入 NMOS 漏极的电流方向刚好相反，所以要加负号 -i(Vds) 才能让曲线是正的。
plot -i(Vds) vs v(drain)
.endc
.end
