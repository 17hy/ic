* delay_slew_50p: CMOS inverter transient response
.include ../models/chapter5_cmos.inc
Vdd vdd 0 2.5
Vin in 0 PULSE(0 2.5 2e-10 5e-11 5e-11 9e-10 2e-09)
Xinv in out vdd inv wnn=1e-06 wpp=2.75e-06 lch=2.5e-07
Cload out 0 2e-14

.control
set noaskquit
set wr_singlescale
set wr_vecnames
tran 1e-12 8.2e-09
wrdata ../raw/delay_slew_50p.dat time v(in) v(out) i(vdd)
quit
.endc
.end
