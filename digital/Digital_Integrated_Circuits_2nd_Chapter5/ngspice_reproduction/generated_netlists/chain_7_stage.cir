* chain_7_stage: 7-stage inverter buffer chain
.include ../models/chapter5_cmos.inc
Vdd vdd 0 2.5
Vin in 0 PULSE(0 2.5 0.2n 20p 20p 1n 2n)
X1 in n1 vdd inv wnn=1e-06 wpp=2.75e-06 lch=2.5e-07
X2 n1 n2 vdd inv wnn=2.293038e-06 wpp=6.3058545e-06 lch=2.5e-07
X3 n2 n3 vdd inv wnn=5.2580232e-06 wpp=1.4459564e-05 lch=2.5e-07
X4 n3 n4 vdd inv wnn=1.2056847e-05 wpp=3.3156329e-05 lch=2.5e-07
X5 n4 n5 vdd inv wnn=2.7646808e-05 wpp=7.6028722e-05 lch=2.5e-07
X6 n5 n6 vdd inv wnn=6.3395181e-05 wpp=0.00017433675 lch=2.5e-07
X7 n6 out vdd inv wnn=0.00014536756 wpp=0.00039976079 lch=2.5e-07
Cload out 0 1e-12

.control
set noaskquit
set wr_singlescale
set wr_vecnames
tran 1p 10n
wrdata ../raw/chain_7_stage.dat time v(in) v(out) i(vdd)
quit
.endc
.end
