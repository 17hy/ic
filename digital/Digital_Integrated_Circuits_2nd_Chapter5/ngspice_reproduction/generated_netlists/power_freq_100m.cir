* power_freq_100m: CMOS inverter transient response
.include ../models/chapter5_cmos.inc
Vdd vdd 0 2.5
Vin in 0 PULSE(0 2.5 1e-09 2e-11 2e-11 4.5e-09 1e-08)
Xinv in out vdd inv wnn=1e-06 wpp=2.75e-06 lch=2.5e-07
Cload out 0 1e-13

.control
set noaskquit
set wr_singlescale
set wr_vecnames
tran 2.5e-12 1.01e-07
wrdata ../raw/power_freq_100m.dat time v(in) v(out) i(vdd)
quit
.endc
.end
